* ELE v9.0.0 Benchmark: Coupled 2-Line RLGC PCB Trace (Crosstalk & Eye)
Vvic vd 0 DC 0
Vagg ad 0 DC 0
Rsv vd vin 50
Rsa ad ain 50
Rlv vout 0 50
Rla aout 0 50
T1 vin vout ain aout 0 R=4.0 L=280n C=112p LM=33.6n CM=16p LEN=0.10 NSEC=8
.TRAN 10p 4n PROBE=vout
.END
